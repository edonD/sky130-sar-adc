* SKY130 SAR ADC — StrongARM Latch Comparator
* Classic StrongARM topology: input pair + cross-coupled inverter latch
* Simpler and more robust than double-tail design

.lib "sky130_models/sky130.lib.spice" tt

* Supply
Vdd vdd 0 DC 1.8
Vss vss 0 DC 0

* Clock — 100 MHz (period 10ns, 5ns eval / 5ns precharge)
Vclk clk 0 PULSE(0 1.8 0 0.1n 0.1n 5n 10n)

* Differential input: +1 LSB differential (7mV)
Vinp inp 0 DC 0.9035
Vinm inm 0 DC 0.8965

* === CDAC Loading Model ===
Rsw_p inp inp_c {Rsw}
Rsw_n inm inm_c {Rsw}
Ccdac_p inp_c vss {Cload}p
Ccdac_n inm_c vss {Cload}p

* === StrongARM Latch Comparator ===

* Tail NMOS (clocked — enables current during evaluation)
XMtail ntail clk vss vss sky130_fd_pr__nfet_01v8 W={Wtail}u L={Ltail}u nf=1

* Input differential pair (NMOS)
XM1 d1 inp_c ntail vss sky130_fd_pr__nfet_01v8 W={Win}u L={Lin}u nf=1
XM2 d2 inm_c ntail vss sky130_fd_pr__nfet_01v8 W={Win}u L={Lin}u nf=1

* Reset PMOS (precharge all internal nodes to VDD when CLK=0)
XMr1 d1 clk vdd vdd sky130_fd_pr__pfet_01v8 W={Wrst}u L=0.15u nf=1
XMr2 d2 clk vdd vdd sky130_fd_pr__pfet_01v8 W={Wrst}u L=0.15u nf=1
XMr3 outn clk vdd vdd sky130_fd_pr__pfet_01v8 W={Wrst}u L=0.15u nf=1
XMr4 outp clk vdd vdd sky130_fd_pr__pfet_01v8 W={Wrst}u L=0.15u nf=1

* Cross-coupled PMOS latch
XMp1 outp outn vdd vdd sky130_fd_pr__pfet_01v8 W={Wlatp}u L={Llatp}u nf=1
XMp2 outn outp vdd vdd sky130_fd_pr__pfet_01v8 W={Wlatp}u L={Llatp}u nf=1

* Cross-coupled NMOS latch (sources to input pair drains for signal coupling)
XMn1 outp outn d1 vss sky130_fd_pr__nfet_01v8 W={Wlatn}u L={Llatn}u nf=1
XMn2 outn outp d2 vss sky130_fd_pr__nfet_01v8 W={Wlatn}u L={Llatn}u nf=1

* Output buffers (inverters for clean digital output)
XMbp1 bufp outp vdd vdd sky130_fd_pr__pfet_01v8 W=2u L=0.15u nf=1
XMbn1 bufp outp vss vss sky130_fd_pr__nfet_01v8 W=1u L=0.15u nf=1
XMbp2 bufn outn vdd vdd sky130_fd_pr__pfet_01v8 W=2u L=0.15u nf=1
XMbn2 bufn outn vss vss sky130_fd_pr__nfet_01v8 W=1u L=0.15u nf=1

.options reltol=0.003 method=gear

* === Measurements ===
.control

* Transient simulation — 3 complete clock cycles
tran 0.05n 30n

* Check comparator output at mid-evaluation of 2nd cycle (13ns)
meas tran outp_val find v(bufp) at=13n
meas tran outm_val find v(bufn) at=13n

* Resolve time: CLK rising edge to output valid
meas tran tclk when v(clk)=0.9 rise=2
meas tran tout when v(bufp)=0.9 rise=2

* Average supply current for power calculation
meas tran avg_idd avg i(Vdd) from=5n to=25n

echo "RESULT_OUTP_VAL $&outp_val"
echo "RESULT_OUTM_VAL $&outm_val"
echo "RESULT_TCLK $&tclk"
echo "RESULT_TOUT $&tout"
echo "RESULT_AVG_IDD $&avg_idd"
echo "RESULT_DONE"
.endc

.end
